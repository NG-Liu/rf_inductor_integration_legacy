printf("deOpenCellView callable=%L\n" isCallable('deOpenCellView))
win = deOpenCellView("codex_fdl_bridge" "single_inductor_12s_3p5t_test" "layout" "maskLayout" nil "a")
printf("OPEN_WINDOW=%L\n" win)
