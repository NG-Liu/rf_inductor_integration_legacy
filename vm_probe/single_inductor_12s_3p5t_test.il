; Auto-generated by tools/fdl_to_cadence.py

procedure(CDX_makeFdlLayout()
  let((libObj cv net term fig pinObj)
    libObj = ddGetObj("codex_fdl_bridge")
    unless(libObj
      libObj = ddCreateLib("codex_fdl_bridge" "/home/IC/EDA/codex_fdl_bridge")
    )
    techBindTechFile(libObj "smic13mmrf_1233")
    cv = dbOpenCellViewByType("codex_fdl_bridge" "single_inductor_12s_3p5t_test" "layout" "maskLayout" "w")
    unless(cv
      error("Failed to open codex_fdl_bridge/single_inductor_12s_3p5t_test/layout")
    )

    dbCreateRect(cv list("BORDER" "drawing") list(-269.3002:-179.3797 359.2207:166.533692))
    ; shape 1: m5
    dbCreatePolygon(cv list("M5" "drawing") list(-34.4538:-60.2503 0.2793:-71.5458 37.0786:-63.6785 65.8005:-37.6844 77.9678:0.2578 69.2503:40.272 40.9122:71.3526 -0.2394:84.39 -43.4679:74.8209 -76.906:44.1378 -85.852:15.6 -96.751:15.6 -85.9947:49.913 -48.4419:84.3716 0.2394:95.1477 46.7157:80.4234 78.8174:45.215 88.7241:-0.2578 74.8506:-43.5206 41.9854:-73.2644 -0.2793:-82.3003 -40.3283:-69.276 -67.7131:-38.7527 -75.5902:-1.0638 -65.4101:1.0638 -58.105:-33.8885))
    ; shape 2: m5
    dbCreatePolygon(cv list("M5" "drawing") list(-80.3904:-46.6659 -47.3617:-82.4607 0.2095:-97.2347 49.8655:-85.9591 88.0163:-50.584 103.6572:0.1972 91.5271:53.0665 53.8052:93.5727 -0.1862:110.0798 -56.2686:97.0945 -99.1298:57.0253 -111.711:15.6 -122.58:15.6 -108.2702:62.7171 -61.3328:106.5971 0.1862:120.8411 59.5143:102.7024 101.0397:58.112 114.4179:-0.1972 97.134:-56.3126 54.8901:-95.4829 -0.2095:-107.9946 -53.112:-91.5648 -89.9268:-51.6669 -98.0204:-15.6 -87.3617:-15.6))
    ; shape 3: m5
    dbCreatePolygon(cv list("M5" "drawing") list(-102.6614:-59.4718 -60.2445:-104.6874 0.1676:-122.9251 62.6757:-108.2279 110.2454:-63.463 129.3477:0.1596 113.794:65.8804 66.6808:115.8039 -0.1523:135.7705 -69.0856:119.3597 -121.3628:69.8981 -137.5106:15.6 -148.3607:15.6 -130.5363:75.5359 -74.2074:128.8311 0.1523:146.5336 72.3303:124.9703 123.272:70.9898 140.1106:-0.1596 119.404:-69.1252 67.7715:-117.7133 -0.1676:-133.6875 -65.9208:-113.8373 -112.155:-64.5526 -123.5817:-15.6 -112.9021:-15.6))
    ; shape 4: m5
    dbCreatePolygon(cv list("M5" "drawing") list(-124.9252:-72.2914 -73.1149:-126.9219 0.1396:-148.616 75.4977:-130.4904 132.4813:-76.3313 155.4332:1.4713 165.4083:-1.4713 141.6673:-81.9485 80.6411:-139.9499 -0.1396:-159.3797 -78.742:-136.1019 -134.3904:-77.4245 -149.188:-15.6 -138.4942:-15.6))
    ; shape 5: v4
    dbCreatePolygon(cv list("V4" "drawing") list(-35.5835:-61.9861 0.1719:-73.614 38.0222:-65.5219 67.5409:-38.8067 80.0363:0.1587 71.0901:41.2225 42.0283:73.097 -0.1473:86.4588 -44.4244:76.6576 -78.6539:45.2484 -87.948:15.6 -94.6551:15.6 -84.2469:48.8024 -47.4854:82.5349 0.1473:93.0789 45.5996:78.679 76.9776:44.2644 86.6556:-0.1587 73.1102:-42.3983 41.0418:-71.421 -0.1719:-80.2321 -39.1986:-67.5403 -65.8654:-37.8172 -73.6325:-0.6547 -67.3678:0.6547 -59.9527:-34.8239))
    ; shape 6: v4
    dbCreatePolygon(cv list("V4" "drawing") list(-82.2244:-47.6276 -48.4675:-84.2115 0.1289:-99.3039 50.8318:-87.7906 89.7697:-51.6857 105.7266:0.1213 93.3565:54.0368 54.9031:95.3284 -0.1146:112.1493 -57.2425:98.9219 -100.8875:58.1199 -113.8012:15.6 -120.4898:15.6 -106.5124:61.6225 -60.3589:104.7697 0.1146:118.7716 58.4164:100.9467 99.2104:57.1417 112.3485:-0.1213 95.3806:-55.2109 53.9239:-93.6514 -0.1289:-105.9254 -52.0062:-89.814 -88.0929:-50.7051 -95.9706:-15.6 -89.4115:-15.6))
    ; shape 7: v4
    dbCreatePolygon(cv list("V4" "drawing") list(-104.4871:-60.4488 -61.3361:-106.447 0.1031:-124.9947 63.6557:-110.052 112.0067:-64.5519 131.4175:0.0982 115.6167:66.8629 67.7673:117.5667 -0.0937:137.8403 -70.0706:121.1811 -123.1269:70.9823 -139.5971:15.6 -146.2741:15.6 -128.7721:74.4517 -73.2224:127.0097 0.0937:144.4638 71.2438:123.2076 121.4493:70.0072 138.0408:-0.0982 117.6428:-68.0363 66.7915:-115.8892 -0.1031:-131.6178 -64.8292:-112.0777 -110.3293:-63.5755 -121.528:-15.6 -114.9559:-15.6))
    ; shape 8: v4
    dbCreatePolygon(cv list("V4" "drawing") list(-126.7454:-73.2786 -74.197:-128.6873 0.0859:-150.6859 76.4868:-132.3096 134.2479:-77.4115 157.3515:0.9054 163.49:-0.9054 139.9008:-80.8683 79.652:-138.1308 -0.0859:-157.3098 -77.6599:-134.3365 -132.5701:-76.4374 -147.1315:-15.6 -140.5507:-15.6))
    ; shape 9: m5
    dbCreatePolygon(cv list("M5" "drawing") list(-65.3002:5.2 -245.3002:5.2 -245.3002:-5.2 -65.3002:-5.2))
    ; shape 10: m5
    dbCreatePolygon(cv list("M5" "drawing") list(155.2207:-5.2 335.2207:-5.2 335.2207:5.2 155.2207:5.2))
    ; shape 11: v4
    dbCreatePolygon(cv list("V4" "drawing") list(155.2207:-3.2 335.2207:-3.2 335.2207:3.2 155.2207:3.2))
    ; shape 12: m4
    dbCreatePolygon(cv list("M4" "drawing") list(155.2207:-5.2 335.2207:-5.2 335.2207:5.2 155.2207:5.2))
    ; shape 13: m4
    dbCreatePolygon(cv list("M4" "drawing") list(-58.105058:-33.888491 -34.453754:-60.250351 0.27933:-71.545872 37.078586:-63.678509 65.800546:-37.684396 77.967854:0.257841 69.250367:40.272003 40.912179:71.352581 -0.239414:84.390023 -43.467875:74.820854 -76.906073:44.137842 -90.812335:-0.223448 -80.390407:-46.665885 -47.361626:-82.460731 0.209478:-97.234754 49.865468:-85.959109 88.016344:-50.584032 103.657255:0.19715 91.527106:53.066521 53.80512:93.572742 -0.186193:110.079821 -56.268628:97.094507 -99.1298:57.025274 -116.502439:-0.176389 -102.661406:-59.471796 -60.244459:-104.687315 0.167569:-122.925096 62.675698:-108.227871 110.245401:-63.462992 129.347789:0.159586 113.793965:65.880403 66.680785:115.803893 -0.152328:135.770508 -69.085625:119.359734 -121.362737:69.898113 -142.193252:-0.145702 -124.925221:-72.291476 -73.114858:-126.921885 0.139628:-148.615915 75.4977:-130.490456 132.481303:-76.331267 155.433195:1.471322 165.408205:-1.471322 141.667297:-81.948533 80.6411:-139.949944 -0.139628:-159.379685 -78.741942:-136.101915 -134.390379:-77.424524 -152.956748:0.145702 -130.536263:75.535887 -74.207375:128.831066 0.152328:146.533692 72.330215:124.970307 123.272035:70.989797 140.110611:-0.159586 119.403999:-69.125208 67.771502:-117.713329 -0.167569:-133.687504 -65.920741:-113.837285 -112.154994:-64.552604 -127.264361:0.176389 -108.2702:62.717126 -61.332772:106.597093 0.186193:120.841179 59.51428:102.702458 101.039694:58.112079 114.417945:-0.19715 97.134056:-56.312568 54.890132:-95.482891 -0.209478:-107.994646 -53.111974:-91.564869 -89.926793:-51.666915 -101.571265:0.223448 -85.994727:49.912958 -48.441925:84.371546 0.239414:95.147777 46.715621:80.423419 78.817433:45.214997 88.724146:-0.257841 74.850654:-43.520604 41.985414:-73.264491 -0.27933:-82.300328 -40.328246:-69.276049 -67.713142:-38.752709 -75.590217:-1.063827 -65.410183:1.063827))
    ; pin P1
    net = dbMakeNet(cv "P1")
    term = dbCreateTerm(net "P1" "inputOutput")
    fig = dbCreateRect(cv list("M5" "drawing") list(-249.3002:-4 -241.3002:4))
    dbAddFigToNet(fig net)
    pinObj = dbCreatePin(net fig "P1" term)
    when(pinObj
      dbReplaceProp(pinObj "accessDir" "string" "bidirectional")
    )
    dbCreateLabel(cv list("M5TXT" "drawing") -245.3002:0 "P1" "centerCenter" "R0" "roman" 8.0)
    ; pin P2
    net = dbMakeNet(cv "P2")
    term = dbCreateTerm(net "P2" "inputOutput")
    fig = dbCreateRect(cv list("M5" "drawing") list(331.2207:-4 339.2207:4))
    dbAddFigToNet(fig net)
    pinObj = dbCreatePin(net fig "P2" term)
    when(pinObj
      dbReplaceProp(pinObj "accessDir" "string" "bidirectional")
    )
    dbCreateLabel(cv list("M5TXT" "drawing") 335.2207:0 "P2" "centerCenter" "R0" "roman" 8.0)

    dbSave(cv)
    dbClose(cv)
    printf("CREATED=codex_fdl_bridge/single_inductor_12s_3p5t_test/layout\n")
    printf("SHAPES=13 PINS=2\n")
  )
)

CDX_makeFdlLayout()
exit()
